* LED SPICE subcircuit
* LED model based on diode with color-specific forward voltages
*
* The forward voltage is controlled by the IS (saturation current) parameter
* Lower IS values result in higher forward voltages
* Typical LED has N=2.0 (higher than regular diode)
*
* Nodes:
*   1 - Anode
*   2 - Cathode

* Red LED - ~1.8V forward voltage
.SUBCKT LED_Red 1 2 PARAMS: IS=1e-16 N=2.0 RS=1 CJO=10p
D1 1 2 LED_RED_MODEL
.MODEL LED_RED_MODEL D(IS={IS} N={N} RS={RS} CJO={CJO})
.ENDS LED_Red

* Green LED - ~2.2V forward voltage
.SUBCKT LED_Green 1 2 PARAMS: IS=1e-18 N=2.0 RS=1 CJO=10p
D1 1 2 LED_GREEN_MODEL
.MODEL LED_GREEN_MODEL D(IS={IS} N={N} RS={RS} CJO={CJO})
.ENDS LED_Green

* Blue LED - ~3.2V forward voltage
.SUBCKT LED_Blue 1 2 PARAMS: IS=1e-20 N=2.0 RS=1 CJO=10p
D1 1 2 LED_BLUE_MODEL
.MODEL LED_BLUE_MODEL D(IS={IS} N={N} RS={RS} CJO={CJO})
.ENDS LED_Blue

* Yellow LED - ~2.0V forward voltage
.SUBCKT LED_Yellow 1 2 PARAMS: IS=1e-17 N=2.0 RS=1 CJO=10p
D1 1 2 LED_YELLOW_MODEL
.MODEL LED_YELLOW_MODEL D(IS={IS} N={N} RS={RS} CJO={CJO})
.ENDS LED_Yellow

* Yellow-green LED - ~2.1V forward voltage
.SUBCKT LED_YellowGreen 1 2 PARAMS: IS=5e-18 N=2.0 RS=1 CJO=10p
D1 1 2 LED_YELLOW_GREEN_MODEL
.MODEL LED_YELLOW_GREEN_MODEL D(IS={IS} N={N} RS={RS} CJO={CJO})
.ENDS LED_YellowGreen

* White LED - ~3.2V forward voltage (similar to blue)
.SUBCKT LED_White 1 2 PARAMS: IS=1e-20 N=2.0 RS=1 CJO=10p
D1 1 2 LED_WHITE_MODEL
.MODEL LED_WHITE_MODEL D(IS={IS} N={N} RS={RS} CJO={CJO})
.ENDS LED_White

* Amber LED - ~2.1V forward voltage
.SUBCKT LED_Amber 1 2 PARAMS: IS=5e-18 N=2.0 RS=1 CJO=10p
D1 1 2 LED_AMBER_MODEL
.MODEL LED_AMBER_MODEL D(IS={IS} N={N} RS={RS} CJO={CJO})
.ENDS LED_Amber

* Orange LED - ~2.0V forward voltage
.SUBCKT LED_Orange 1 2 PARAMS: IS=1e-17 N=2.0 RS=1 CJO=10p
D1 1 2 LED_ORANGE_MODEL
.MODEL LED_ORANGE_MODEL D(IS={IS} N={N} RS={RS} CJO={CJO})
.ENDS LED_Orange

* Pink LED - ~2.8V forward voltage
.SUBCKT LED_Pink 1 2 PARAMS: IS=1e-19 N=2.0 RS=1 CJO=10p
D1 1 2 LED_PINK_MODEL
.MODEL LED_PINK_MODEL D(IS={IS} N={N} RS={RS} CJO={CJO})
.ENDS LED_Pink

* UV LED - ~3.5V forward voltage
.SUBCKT LED_UV 1 2 PARAMS: IS=1e-21 N=2.0 RS=1 CJO=10p
D1 1 2 LED_UV_MODEL
.MODEL LED_UV_MODEL D(IS={IS} N={N} RS={RS} CJO={CJO})
.ENDS LED_UV

* Generic LED - default characteristics (~2.0V)
.SUBCKT LED_Other 1 2 PARAMS: IS=1e-17 N=2.0 RS=1 CJO=10p
D1 1 2 LED_OTHER_MODEL
.MODEL LED_OTHER_MODEL D(IS={IS} N={N} RS={RS} CJO={CJO})
.ENDS LED_Other
XD1 PWR_LED_A GND LED_Green IS=1e-18 N=2.0 RS=1 CJO=10p
XD2 STATUS_LED_A GND LED_Blue IS=1e-20 N=2.0 RS=1 CJO=10p
* Resistor SPICE subcircuit
* Model with parasitic series inductance and parallel capacitance
*
* Equivalent circuit:
*
*              ┌── Cp ──┐
*   1 ── ESL ──┤        ├── 2
*              └── R ───┘
*
* Behavior:
*   f << SRF: Z ≈ R (purely resistive)
*   f ~ SRF:  Parallel resonance of L and Cp; impedance peaks for low R,
*             dips for high R
*   f >> SRF: Cp dominates (capacitive roll-off)
*
* Parameters:
*   RVAL - Resistance value in ohms
*   ESL  - Parasitic series inductance (henries)
*   CP   - Parasitic parallel capacitance (farads)

.SUBCKT R 1 2 PARAMS: RVAL=1k ESL=0.5n CP=0.05p
L_esl 1 mid {ESL}
R1 mid 2 {RVAL}
C_p mid 2 {CP}
.ENDS R
XR1 V5 PWR_LED_A R RVAL=1k ESL=700p CP=80f
XR2 GPIO STATUS_LED_A R RVAL=330 ESL=700p CP=80f

V_5 V5 GND DC 5
V_IO GPIO GND DC 3.3
.control
  op
  echo "I_PWR_LED_mA =" $&@v_5[i]
  let ipwr = -i(V_5)*1000
  let ists = -i(V_IO)*1000
  print ipwr ists
  echo "VF_status =" $&v(STATUS_LED_A)
.endc
