* Capacitor SPICE subcircuit
* Series RLC model capturing parasitic ESR and ESL
*
* Equivalent circuit:
*
*   1 ── ESL ── ESR ── C ── 2
*
* Behavior:
*   f < SRF:  Impedance dominated by C (capacitive, |Z| falls with f)
*   f = SRF:  Impedance minimum at ESR (series resonance of C and ESL)
*   f > SRF:  Impedance dominated by ESL (inductive, |Z| rises with f)
*
* Parameters:
*   CVAL - Capacitance value in farads
*   ESR  - Equivalent series resistance (ohms)
*   ESL  - Equivalent series inductance (henries)

.SUBCKT C 1 2 PARAMS: CVAL=100n ESR=10m ESL=500p
L_esl 1 mid1 {ESL}
R_esr mid1 mid2 {ESR}
C1 mid2 2 {CVAL}
.ENDS C
XC1 BUTTON GND C CVAL=100n ESR=3m ESL=700p
* Resistor SPICE subcircuit
* Model with parasitic series inductance and parallel capacitance
*
* Equivalent circuit:
*
*              ┌── Cp ──┐
*   1 ── ESL ──┤        ├── 2
*              └── R ───┘
*
* Behavior:
*   f << SRF: Z ≈ R (purely resistive)
*   f ~ SRF:  Parallel resonance of L and Cp; impedance peaks for low R,
*             dips for high R
*   f >> SRF: Cp dominates (capacitive roll-off)
*
* Parameters:
*   RVAL - Resistance value in ohms
*   ESL  - Parasitic series inductance (henries)
*   CP   - Parasitic parallel capacitance (farads)

.SUBCKT R 1 2 PARAMS: RVAL=1k ESL=0.5n CP=0.05p
L_esl 1 mid {ESL}
R1 mid 2 {RVAL}
C_p mid 2 {CP}
.ENDS R
XR1 V3V3 BUTTON R RVAL=10k ESL=700p CP=80f

V_33 V3V3 GND DC 3.3
* push at 2 ms with 3 bounces of 100 us, release at 20 ms with 3 bounces
V_SW CTL GND PWL(0 0 2m 0 2.001m 1 2.1m 1 2.101m 0 2.2m 0 2.201m 1 2.3m 1 2.301m 0 2.4m 0 2.401m 1
+ 20m 1 20.001m 0 20.1m 0 20.101m 1 20.2m 1 20.201m 0 30m 0)
S_BTN BUTTON GND CTL GND SWB
.model SWB SW(RON=0.1 ROFF=1e9 VT=0.5 VH=0.1)
.control
  tran 2u 30m
  meas tran t_low WHEN v(BUTTON)=0.825 FALL=1
  meas tran vmax_during_bounce MAX v(BUTTON) FROM=2.11m TO=2.5m
  meas tran t_high WHEN v(BUTTON)=2.475 RISE=LAST
  meas tran vmin_release_bounce MIN v(BUTTON) FROM=20.11m TO=20.3m
.endc
